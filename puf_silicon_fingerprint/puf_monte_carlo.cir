* Monte Carlo Simulation of 8 Silicon Dies for PUF
* Demonstrates unique key generation across different chip dies

.title PUF Monte Carlo Die Variations

.include puf_cell.cir

.control
  let runs = 8
  let count = 0

  echo "================================================="
  echo " Simulating 8 Independent Silicon PUF Dies..."
  echo "================================================="

  dowhile count < runs
    * Introduce random Gaussian threshold voltage mismatch on MP1 and MN1
    let vto_p1 = -0.45 + gauss(0.04)
    let vto_n1 =  0.45 + gauss(0.04)

    altermod @pmos_puf[vto] = vto_p1
    altermod @nmos_puf[vto] = vto_n1

    tran 0.1n 50n

    * Measure resolved state at 40ns
    meas tran final_Q find v(Q) at=40n

    if final_Q > 0.9
      echo "Die #" count "-> Resolved Key Bit: [ 1 ]"
    else
      echo "Die #" count "-> Resolved Key Bit: [ 0 ]"
    end

    let count = count + 1
  end
.endc
.end
