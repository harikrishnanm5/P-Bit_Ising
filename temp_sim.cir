* ==============================================================================
* 4-p-Bit Reconfigurable Transistor-Level Ising Optimization Core
* Standardized 180nm CMOS with CMOS Transmission-Gate Coupling Network
* ==============================================================================

.title 4-p-Bit Reconfigurable CMOS Ising Optimization Core

* ------------------------------------------------------------------------------
* Power Supply & Mode Control
* MODE = 1.8V (or 5V): 4-p-bit Mode (All 5 edges active)
* MODE = 0.0V:        2-p-bit Mode (Only P1-P2 active, P3 & P4 isolated)
* ------------------------------------------------------------------------------
Vdd vdd 0 DC 1.8V
Vmode mode 0 DC 1.8V

* Complementary MODE Generation (Inverter)
MP_INV mode_bar mode vdd vdd PMOS_PBIT W=2.5u L=0.18u
MN_INV mode_bar mode 0   0   NMOS_PBIT W=1.0u L=0.18u

* ------------------------------------------------------------------------------
* CMOS 180nm Calibrated Transistor Models
* ------------------------------------------------------------------------------
.model NMOS_PBIT NMOS (LEVEL=1 VTO=0.45 KP=150u GAMMA=0.4 PHI=0.6 LAMBDA=0.05)
.model PMOS_PBIT PMOS (LEVEL=1 VTO=-0.45 KP=60u GAMMA=0.4 PHI=0.6 LAMBDA=0.05)

* ------------------------------------------------------------------------------
* DC Mid-Rail Operating Point Biases (Vth_actual = 0.90V)
* ------------------------------------------------------------------------------
Vbias1 in1 0 DC 0.90V
Vbias2 in2 0 DC 0.90V
Vbias3 in3 0 DC 0.90V
Vbias4 in4 0 DC 0.90V

* ------------------------------------------------------------------------------
* Independent Quasi-Random / Dither Noise Sources (P1 - P4)
* ------------------------------------------------------------------------------
Vnoise1 noise1 in1 SIN(0 40m 5.0k 0 0)
Vnoise2 noise2 in2 SIN(0 40m 7.1k 0 0)
Vnoise3 noise3 in3 SIN(0 40m 11.3k 0 0)
Vnoise4 noise4 in4 SIN(0 40m 13.7k 0 0)

* ==============================================================================
* Four Discrete CMOS Probabilistic Bit (p-bit) Cells: P1 - P4
* ==============================================================================

* --- p-Bit Cell P1 ---
MP1 a1 noise1 vdd vdd PMOS_PBIT W=2.5u L=0.18u
MN1 a1 noise1 0   0   NMOS_PBIT W=1.0u L=0.18u
Rfb1 noise1 a1 500k
C1 a1 0 15fF
MP_BUF1 m_out1 a1 vdd vdd PMOS_PBIT W=3.0u L=0.18u
MN_BUF1 m_out1 a1 0   0   NMOS_PBIT W=1.5u L=0.18u
Cout1 m_out1 0 20fF

* --- p-Bit Cell P2 ---
MP2 a2 noise2 vdd vdd PMOS_PBIT W=2.5u L=0.18u
MN2 a2 noise2 0   0   NMOS_PBIT W=1.0u L=0.18u
Rfb2 noise2 a2 500k
C2 a2 0 15fF
MP_BUF2 m_out2 a2 vdd vdd PMOS_PBIT W=3.0u L=0.18u
MN_BUF2 m_out2 a2 0   0   NMOS_PBIT W=1.5u L=0.18u
Cout2 m_out2 0 20fF

* --- p-Bit Cell P3 ---
MP3 a3 noise3 vdd vdd PMOS_PBIT W=2.5u L=0.18u
MN3 a3 noise3 0   0   NMOS_PBIT W=1.0u L=0.18u
Rfb3 noise3 a3 500k
C3 a3 0 15fF
MP_BUF3 m_out3 a3 vdd vdd PMOS_PBIT W=3.0u L=0.18u
MN_BUF3 m_out3 a3 0   0   NMOS_PBIT W=1.5u L=0.18u
Cout3 m_out3 0 20fF

* --- p-Bit Cell P4 ---
MP4 a4 noise4 vdd vdd PMOS_PBIT W=2.5u L=0.18u
MN4 a4 noise4 0   0   NMOS_PBIT W=1.0u L=0.18u
Rfb4 noise4 a4 500k
C4 a4 0 15fF
MP_BUF4 m_out4 a4 vdd vdd PMOS_PBIT W=3.0u L=0.18u
MN_BUF4 m_out4 a4 0   0   NMOS_PBIT W=1.5u L=0.18u
Cout4 m_out4 0 20fF

* ==============================================================================
* 5-Edge MAX-CUT Reconfigurable Coupling Network (Symmetric Inhibitory Feedback)
* ==============================================================================

* Edge 1: P1 - P2 (Permanent / Always Active Edge)
R_c12 a1 noise2 500k
R_c21 a2 noise1 500k

* Edge 2: P1 - P3 (Switchable via CMOS Transmission Gates)
R_c13 a1 tg_13 500k
MN_TG13 tg_13 mode noise3 0 NMOS_PBIT W=1.0u L=0.18u
MP_TG13 tg_13 mode_bar noise3 vdd PMOS_PBIT W=2.5u L=0.18u

R_c31 a3 tg_31 500k
MN_TG31 tg_31 mode noise1 0 NMOS_PBIT W=1.0u L=0.18u
MP_TG31 tg_31 mode_bar noise1 vdd PMOS_PBIT W=2.5u L=0.18u

* Edge 3: P2 - P3 (Switchable via CMOS Transmission Gates)
R_c23 a2 tg_23 500k
MN_TG23 tg_23 mode noise3 0 NMOS_PBIT W=1.0u L=0.18u
MP_TG23 tg_23 mode_bar noise3 vdd PMOS_PBIT W=2.5u L=0.18u

R_c32 a3 tg_32 500k
MN_TG32 tg_32 mode noise2 0 NMOS_PBIT W=1.0u L=0.18u
MP_TG32 tg_32 mode_bar noise2 vdd PMOS_PBIT W=2.5u L=0.18u

* Edge 4: P2 - P4 (Switchable via CMOS Transmission Gates)
R_c24 a2 tg_24 500k
MN_TG24 tg_24 mode noise4 0 NMOS_PBIT W=1.0u L=0.18u
MP_TG24 tg_24 mode_bar noise4 vdd PMOS_PBIT W=2.5u L=0.18u

R_c42 a4 tg_42 500k
MN_TG42 tg_42 mode noise2 0 NMOS_PBIT W=1.0u L=0.18u
MP_TG42 tg_42 mode_bar noise2 vdd PMOS_PBIT W=2.5u L=0.18u

* Edge 5: P3 - P4 (Switchable via CMOS Transmission Gates)
R_c34 a3 tg_34 500k
MN_TG34 tg_34 mode noise4 0 NMOS_PBIT W=1.0u L=0.18u
MP_TG34 tg_34 mode_bar noise4 vdd PMOS_PBIT W=2.5u L=0.18u

R_c43 a4 tg_43 500k
MN_TG43 tg_43 mode noise3 0 NMOS_PBIT W=1.0u L=0.18u
MP_TG43 tg_43 mode_bar noise3 vdd PMOS_PBIT W=2.5u L=0.18u

* ==============================================================================
* Transient Analysis & Simulation Control
* ==============================================================================
.tran 100n 1m

.control
  run
  wrdata ising_results.txt v(m_out1) v(m_out2) v(m_out3) v(m_out4) v(a1) v(a2) v(a3) v(a4)
  quit
  run
  set color0=white
  set color1=black
  plot v(m_out1) v(m_out2) v(m_out3) v(m_out4) title '4-p-Bit Ising Core: Digital Output Spins'
  plot v(a1) v(a2) v(a3) v(a4) title '4-p-Bit Ising Core: Analog Metastable Potentials'
.endc

.end
