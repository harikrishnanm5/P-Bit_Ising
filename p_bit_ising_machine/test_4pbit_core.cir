* 4-p-bit Transistor-Level Ising Core
.title 4-p-bit Transistor-Level Ising Core

* Power Supply & Mode Control
Vdd vdd 0 DC 1.8V
Vmode mode 0 DC 1.8V

* Mode Inverter for Complementary Control
MP_INV mode_bar mode vdd vdd PMOS_PBIT W=2.5u L=0.18u
MN_INV mode_bar mode 0   0   NMOS_PBIT W=1.0u L=0.18u

* Transistor Models
.model NMOS_PBIT NMOS (LEVEL=1 VTO=0.45 KP=150u GAMMA=0.4 PHI=0.6 LAMBDA=0.05)
.model PMOS_PBIT PMOS (LEVEL=1 VTO=-0.45 KP=60u GAMMA=0.4 PHI=0.6 LAMBDA=0.05)

* DC Input Biases
Vbias1 in1 0 DC 0.90V
Vbias2 in2 0 DC 0.90V
Vbias3 in3 0 DC 0.90V
Vbias4 in4 0 DC 0.90V

* Dither / Noise Sources
Vnoise1 noise1 in1 SIN(0 40m 5.0k 0 0)
Vnoise2 noise2 in2 SIN(0 40m 7.1k 0 0)
Vnoise3 noise3 in3 SIN(0 40m 11.3k 0 0)
Vnoise4 noise4 in4 SIN(0 40m 13.7k 0 0)

* --- P-bit 1 ---
MP1 a1 noise1 vdd vdd PMOS_PBIT W=2.5u L=0.18u
MN1 a1 noise1 0   0   NMOS_PBIT W=1.0u L=0.18u
Rfb1 noise1 a1 500k
C1 a1 0 15fF
MP_BUF1 m_out1 a1 vdd vdd PMOS_PBIT W=3.0u L=0.18u
MN_BUF1 m_out1 a1 0   0   NMOS_PBIT W=1.5u L=0.18u
Cout1 m_out1 0 20fF

* --- P-bit 2 ---
MP2 a2 noise2 vdd vdd PMOS_PBIT W=2.5u L=0.18u
MN2 a2 noise2 0   0   NMOS_PBIT W=1.0u L=0.18u
Rfb2 noise2 a2 500k
C2 a2 0 15fF
MP_BUF2 m_out2 a2 vdd vdd PMOS_PBIT W=3.0u L=0.18u
MN_BUF2 m_out2 a2 0   0   NMOS_PBIT W=1.5u L=0.18u
Cout2 m_out2 0 20fF

* --- P-bit 3 ---
MP3 a3 noise3 vdd vdd PMOS_PBIT W=2.5u L=0.18u
MN3 a3 noise3 0   0   NMOS_PBIT W=1.0u L=0.18u
Rfb3 noise3 a3 500k
C3 a3 0 15fF
MP_BUF3 m_out3 a3 vdd vdd PMOS_PBIT W=3.0u L=0.18u
MN_BUF3 m_out3 a3 0   0   NMOS_PBIT W=1.5u L=0.18u
Cout3 m_out3 0 20fF

* --- P-bit 4 ---
MP4 a4 noise4 vdd vdd PMOS_PBIT W=2.5u L=0.18u
MN4 a4 noise4 0   0   NMOS_PBIT W=1.0u L=0.18u
Rfb4 noise4 a4 500k
C4 a4 0 15fF
MP_BUF4 m_out4 a4 vdd vdd PMOS_PBIT W=3.0u L=0.18u
MN_BUF4 m_out4 a4 0   0   NMOS_PBIT W=1.5u L=0.18u
Cout4 m_out4 0 20fF

* ==============================================================================
* Coupling Network (5 Edges, Symmetric Inhibitory Cross-Coupling)
* ==============================================================================
* Edge 1: P1 - P2 (Always Connected)
R_c12 a1 noise2 500k
R_c21 a2 noise1 500k

* Edge 2: P1 - P3 (Switchable via Transmission Gates)
R_c13 a1 tg_13 500k
MN_TG13 tg_13 mode noise3 0 NMOS_PBIT W=1.0u L=0.18u
MP_TG13 tg_13 mode_bar noise3 vdd PMOS_PBIT W=2.5u L=0.18u

R_c31 a3 tg_31 500k
MN_TG31 tg_31 mode noise1 0 NMOS_PBIT W=1.0u L=0.18u
MP_TG31 tg_31 mode_bar noise1 vdd PMOS_PBIT W=2.5u L=0.18u

* Edge 3: P2 - P3 (Switchable via Transmission Gates)
R_c23 a2 tg_23 500k
MN_TG23 tg_23 mode noise3 0 NMOS_PBIT W=1.0u L=0.18u
MP_TG23 tg_23 mode_bar noise3 vdd PMOS_PBIT W=2.5u L=0.18u

R_c32 a3 tg_32 500k
MN_TG32 tg_32 mode noise2 0 NMOS_PBIT W=1.0u L=0.18u
MP_TG32 tg_32 mode_bar noise2 vdd PMOS_PBIT W=2.5u L=0.18u

* Edge 4: P2 - P4 (Switchable via Transmission Gates)
R_c24 a2 tg_24 500k
MN_TG24 tg_24 mode noise4 0 NMOS_PBIT W=1.0u L=0.18u
MP_TG24 tg_24 mode_bar noise4 vdd PMOS_PBIT W=2.5u L=0.18u

R_c42 a4 tg_42 500k
MN_TG42 tg_42 mode noise2 0 NMOS_PBIT W=1.0u L=0.18u
MP_TG42 tg_42 mode_bar noise2 vdd PMOS_PBIT W=2.5u L=0.18u

* Edge 5: P3 - P4 (Switchable via Transmission Gates)
R_c34 a3 tg_34 500k
MN_TG34 tg_34 mode noise4 0 NMOS_PBIT W=1.0u L=0.18u
MP_TG34 tg_34 mode_bar noise4 vdd PMOS_PBIT W=2.5u L=0.18u

R_c43 a4 tg_43 500k
MN_TG43 tg_43 mode noise3 0 NMOS_PBIT W=1.0u L=0.18u
MP_TG43 tg_43 mode_bar noise3 vdd PMOS_PBIT W=2.5u L=0.18u

.tran 100n 1m

.control
  run
  wrdata sim_out.txt v(m_out1) v(m_out2) v(m_out3) v(m_out4)
  quit
.endc
.end
