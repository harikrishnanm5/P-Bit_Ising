* 4-p-Bit Reconfigurable Ising Optimization Core
.title 4-p-Bit Reconfigurable Ising Optimization Core

* Power Supply & Mode Selection (5V = 4-p-bit mode, 0V = 2-p-bit mode)
Vdd vdd 0 DC 5V
Vmode mode 0 DC 5V

* Noise Sources (Multi-Tone Asynchronous Quasi-Random Generators)
Vn1 n1 0 SFFM(0 1.5 35k 1.8 9k)
Vn2 n2 0 SFFM(0 1.5 43k 1.6 13k)
Vn3 n3 0 SFFM(0 1.5 27k 1.4 7k)
Vn4 n4 0 SFFM(0 1.5 51k 1.9 17k)

* Normalized Spin Definitions: s_i = (V(out_i) - 2.5) / 2.5 in [-1, +1]
* Enable Logic for P3 and P4:
Ben34 en34 0 V = if(V(mode) > 2.5, 1, 0)

* Synaptic Summing Junctions (Inhibitory / Antiferromagnetic Coupling)
* Graph: (1,2), (1,3), (2,3), (2,4), (3,4) - No (1,4)
Bsum1 sum1 0 V = V(n1) - ((V(out2)-2.5)/2.5) - V(en34)*((V(out3)-2.5)/2.5)
Bsum2 sum2 0 V = V(n2) - ((V(out1)-2.5)/2.5) - V(en34)*((V(out3)-2.5)/2.5) - V(en34)*((V(out4)-2.5)/2.5)
Bsum3 sum3 0 V = V(en34) * (V(n3) - ((V(out1)-2.5)/2.5) - ((V(out2)-2.5)/2.5) - ((V(out4)-2.5)/2.5))
Bsum4 sum4 0 V = V(en34) * (V(n4) - ((V(out2)-2.5)/2.5) - ((V(out3)-2.5)/2.5))

* Nonlinear Activation / Slicing Stage
Braw1 raw1 0 V = if(V(sum1) > 0, 5, 0)
Braw2 raw2 0 V = if(V(sum2) > 0, 5, 0)
Braw3 raw3 0 V = if(V(en34) > 0.5, if(V(sum3) > 0, 5, 0), 0)
Braw4 raw4 0 V = if(V(en34) > 0.5, if(V(sum4) > 0, 5, 0), 0)

* RC Low-Pass Dynamics (Breaks Algebraic Loops & Simulates Physical Slew)
R1 raw1 out1 1k
C1 out1 0 10n

R2 raw2 out2 1k
C2 out2 0 10n

R3 raw3 out3 1k
C3 out3 0 10n

R4 raw4 out4 1k
C4 out4 0 10n

* Real-Time Energy / Hamiltonian Metric: H = -sum(J_ij * s_i * s_j)
* In MAX-CUT, lower energy = more satisfied cut edges
Benergy energy 0 V = ((V(out1)-2.5)*(V(out2)-2.5) + V(en34)*(V(out1)-2.5)*(V(out3)-2.5) + V(en34)*(V(out2)-2.5)*(V(out3)-2.5) + V(en34)*(V(out2)-2.5)*(V(out4)-2.5) + V(en34)*(V(out3)-2.5)*(V(out4)-2.5)) / 6.25

.tran 100n 200u

.control
  run
  set color0=white
  set color1=black
  plot v(out1) v(out2) v(out3) v(out4) title '4-p-Bit Reconfigurable Ising Core: Convergence to MAX-CUT Ground State'
  plot v(energy) title 'Ising Hamiltonian Energy Minimization Trajectory'
.endc

.end
